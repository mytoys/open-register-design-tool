// wide registers
// rollover, saturating counters, thresholds
// cascading counters
// name, description params
// external regfile

field swcfg_field {
     hw   = r; sw = rw;
     desc = "SW Configuration field";
};

regfile regs_CACC {
	reg {
        category = "STATE";
		swcfg_field xx_enable[31:31] = 1'd1;
		swcfg_field set_back[26:16] = 11'd16;
		swcfg_field size[10:0] = 11'd128;
	} reorder_window;
	reg {
        category = "STATE";
		swcfg_field bypass[0:0] = 1'd0;
		swcfg_field thrd[6:4] = 3'd2;
		swcfg_field gain[15:8] = 8'd64;
	} agc_gain;
};

addrmap  {
	regs_CACC CACC @0x1000;
} test;    


