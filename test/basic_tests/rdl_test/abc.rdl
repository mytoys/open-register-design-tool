// wide registers
// rollover, saturating counters, thresholds
// cascading counters
// name, description params
// external regfile

field f_RW { hw = r; sw = rw; desc = "TBD"; };
field f_RO { hw = w; sw = r ; desc = "TBD"; };


// regfile is the boundry of register address
// a regfile has a configured base_address
// and inside regfile, reg address is continuous
//
regfile regs_ABC  {
    reg {
        f_RW field_name[31:0] = 8'd0;
        field_name->desc = "enable";
    } reg_0_name;
    reg_0_name->desc = "register description text for ENABLE";

    reg {
        f_RW field_name[7:0] = 8'd0;
    } reg_1_name @0x20;

    reg {
        f_RW field_31[31:31] = 1'd1;
        field_31->desc = "field description text for field_31";

        f_RW field_26[26:16] = 11'd16;
        field_26->desc = "field description text for field_26";

        f_RW field_10_0[10:0] = 11'd128;
        field_10_0->desc = "field description text for field_10_0";

    } CTRL;
    CTRL->desc = "register description text for CTRL";

};

// addrmap is the boundry of RTL
// output verilog will be
//  $(addrmap)_pio
//    +$(addrmap)_logic
//    +$(addrmap)_decode
addrmap  {
    regs_ABC  ABC    @0x000;

/*
    regs_ABC  ABC_2  @0x1000;

    reg {
        f_RW status[15:0] = 1'd0;
    } STATUS;

    regs_ABC  ABC_3  @0x2000;
*/

} abc;

